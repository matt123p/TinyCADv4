TinyCAD simulation

.temp 27
C1 OUT 0 1u IC=0V
R1 IN OUT 1k
V1 IN 0 DC 0 AC 1 0

.save i(V1) v(IN) v(OUT) v(in) v(out)
.ac dec 100 1 100000
.end
