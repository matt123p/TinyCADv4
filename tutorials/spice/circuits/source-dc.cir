TinyCAD simulation

.temp 27
R1 OUT 0 1k
V1 OUT 0 DC 5 AC 0 0

.save i(V1) v(OUT) v(out)
.tran 0.000002 0.005 0 0.000002
.end
