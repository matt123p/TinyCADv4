TinyCAD simulation

.temp 27
E1 OUT 0 IN 0 2
R1 OUT 0 1k
V1 IN 0 DC 0 AC 0 0 SIN(0 1 1000 0 0 0)

.save i(E1) i(V1) v(IN) v(OUT) v(in) v(out)
.tran 0.000002 0.005 0 0.000002
.end
