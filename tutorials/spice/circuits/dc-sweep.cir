TinyCAD simulation

.temp 27
R1 IN OUT 1k
R2 OUT 0 1k
V1 IN 0 DC 5 AC 0 0

.save i(V1) v(IN) v(OUT) v(in) v(out)
.dc V1 0 10 0.5
.end
