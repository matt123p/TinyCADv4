TinyCAD simulation

.temp 27
R1 OUT 0 1k
V1 OUT 0 DC 0 AC 0 0 PULSE(0 5 0 0.000009999999999999999 0.000009999999999999999 0.0003 0.001)

.save i(V1) v(OUT) v(out)
.tran 0.000002 0.005 0 0.000002
.end
