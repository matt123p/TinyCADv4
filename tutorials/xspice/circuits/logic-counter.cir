TinyCAD simulation

.temp 27
.subckt TUTORIAL_LOGIC CLK RESET Q0 Q1 Q2 Q3
.model adc adc_bridge(in_low=1 in_high=3)
.model dac dac_bridge(out_low=0 out_high=5 out_undef=2.5 t_rise=5n t_fall=5n)
Ain [CLK RESET] [dc dr] adc
.model flip d_dff(ic=0 clk_delay=20n reset_delay=20n rise_delay=5n fall_delay=5n)
Af0 n0 dc NULL dr q0 n0 flip
Af1 n1 n0 NULL dr q1 n1 flip
Af2 n2 n1 NULL dr q2 n2 flip
Af3 n3 n2 NULL dr q3 n3 flip
Aout [q0 q1 q2 q3] [Q0 Q1 Q2 Q3] dac
.ends TUTORIAL_LOGIC
V1 CLK 0 DC 0 AC 0 0 PULSE(0 5 5.000000000000001e-7 5e-9 5e-9 5.000000000000001e-7 0.000001)
V2 RESET 0 DC 0 AC 0 0 PULSE(0 5 0 5e-9 5e-9 1.0000000000000001e-7 0.00009999999999999999)
X1 CLK RESET Q0 Q1 Q2 Q3 TUTORIAL_LOGIC

.save i(V1) i(V2) v(CLK) v(RESET) v(Q0) v(Q1) v(Q2) v(Q3) v(clk) v(reset) v(q0) v(q1) v(q2) v(q3)
.tran 2e-9 0.000018 0 2e-9
.end
